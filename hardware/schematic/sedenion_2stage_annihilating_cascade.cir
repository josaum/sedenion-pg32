* ==============================================================================
* SPICE3 / NGSPICE / LTSPICE NETLIST: 2-STAGE MUTUALLY-ANNIHILATING CASCADE
* Drawing Number : SCH-NSSP-200-A
* Architecture   : 2-Stage Pre-ADC Non-Associative Sedenion Cascade ((R * W1) * W2)
* Key Theorem    : Lean 4 Theorem 5.39 (w1 * w2 = 0, yet (e_2 * w1) * w2 = [e_2, w1, w2] != 0)
* Verified       : Zero-Axiom Lean 4.15.0 + SPICE Monte Carlo (0.01% Foil >80 dB Dual Null)
* ==============================================================================
*
* DUAL NON-COAXIAL +80 dB JSR JAMMER SCENARIO (Lean 4 Theorem 5.39):
*   - Jammer 1: U1 = (e_1 + e_10)/sqrt(2)  [Box-Kite Axis n(U1) = +e_3]
*   - Jammer 2: U2 = (e_1 + e_13)/sqrt(2)  [Box-Kite Axis n(U2) = -e_4]
*     Since n(U1) != n(U2), ker R(U1) cap ker R(U2) = {0}: NO 1-stage linear or
*     sedenion weight can cancel both U1 and U2!
*   - Stage 1 Crossbar (2-Tap): W1 = (e_4 - e_15)/sqrt(2)
*       * Annihilates U1 at Stage 1 output: U1 * W1 = 0
*       * Maps U2 onto zero-divisor cone:   U2' = U2 * W1 = (-e_2 + e_5 - e_9 + e_14)/sqrt(2)
*       * Maps desired signal S = e_2 to:   S'  = e_2 * W1 = (e_6 - e_13)/sqrt(2)
*   - Inter-Stage Isolation Buffer: Analog Devices ADL5565 (6 GHz, +46 dBm OIP3, Av = 0 dB)
*   - Stage 2 Crossbar (4-Tap LT5400AIMS8E-1 Quad Foil): W2 = (e_1 - e_6 + e_10 - e_13)/2
*       * MUTUAL FILTER ANNIHILATION:       W1 * W2 = 0  (Dead circuit in any associative ring!)
*       * Annihilates Stage-1 U2 residual:  (U2 * W1) * W2 = 0
*       * Transmits Desired Signal S = e_2 strictly via the non-associative associator:
*           (e_2 * W1) * W2 = [e_2, W1, W2] != 0  (||(e_2 * (e_4 - e_15)) * (e_1 - e_6 + e_10 - e_13)||_2 = 2.0!)
*   - (Note: For Antipodal Dual-Pol Jammers U1 = e_1 + e_10, U2 = e_1 - e_10, Stage 2 simplifies
*     to 2-Tap Mode A: W2_anti = (e_1 + e_10)/sqrt(2) by disabling Taps C & D via ADG1606 EN=0.)
* ==============================================================================

.PARAM R_ON_MUX   = 4.5
.PARAM R_ON_DPDT  = 0.5
.PARAM R_OFF_DPDT = 1.0G
.PARAM R_SUM_FOIL = 1000.0
.PARAM R_SHUNT_2T = 1414.21356
.PARAM R_SHUNT_4T = 1000.0
.PARAM R_FILT     = 49.9
.PARAM C_FILT     = 33.0p

* ------------------------------------------------------------------------------
* SUBCKT: ADG1611_DPDT_BRIDGE (Differential +/-1 Sign-Bit Polarity Inverter)
* ------------------------------------------------------------------------------
.SUBCKT ADG1611_DPDT_BRIDGE IN_P IN_N OUT_P OUT_N CTRL_POL AGND
S_SW1 IN_P OUT_P CTRL_POL AGND SW_NORM_CLOSED
S_SW4 IN_N OUT_N CTRL_POL AGND SW_NORM_CLOSED
S_SW2 IN_P OUT_N CTRL_POL AGND SW_NORM_OPEN
S_SW3 IN_N OUT_P CTRL_POL AGND SW_NORM_OPEN
C_PAR_P OUT_P AGND 12.0p
C_PAR_N OUT_N AGND 12.0p
.MODEL SW_NORM_CLOSED SW(VT=1.65 VH=0.1 RON=1.0G ROFF=0.5)
.MODEL SW_NORM_OPEN   SW(VT=1.65 VH=0.1 RON=0.5  ROFF=1.0G)
.ENDS ADG1611_DPDT_BRIDGE

* ------------------------------------------------------------------------------
* SUBCKT: FOIL_2TAP_SUMMER (Stage-1 0.01% Foil + AD8130 Receiver, Scale = 1/sqrt(2))
* ------------------------------------------------------------------------------
.SUBCKT FOIL_2TAP_SUMMER VA_P VA_N VB_P VB_N VOUT_P VOUT_N AGND
R_MUX_AP VA_P VA_INT_P {R_ON_MUX}
R_MUX_AN VA_N VA_INT_N {R_ON_MUX}
R_MUX_BP VB_P VB_INT_P {R_ON_MUX}
R_MUX_BN VB_N VB_INT_N {R_ON_MUX}
R1_FOIL VA_INT_P SUM_P {R_SUM_FOIL}
R2_FOIL VA_INT_N SUM_N {R_SUM_FOIL}
R3_FOIL VB_INT_P SUM_P {R_SUM_FOIL}
R4_FOIL VB_INT_N SUM_N {R_SUM_FOIL}
R5_SHUNT SUM_P AGND {R_SHUNT_2T}
R6_SHUNT SUM_N AGND {R_SHUNT_2T}
E_AMP_P AMP_P AGND SUM_P SUM_N 0.85355339
E_AMP_N AMP_N AGND SUM_N SUM_P 0.85355339
R7_OUT AMP_P VOUT_P {R_FILT}
R8_OUT AMP_N VOUT_N {R_FILT}
C5_AA  VOUT_P VOUT_N {C_FILT}
R_TERM VOUT_P VOUT_N 100.0K
.ENDS FOIL_2TAP_SUMMER

* ------------------------------------------------------------------------------
* SUBCKT: LT5400_4TAP_SUMMER (Stage-2 Quad Matched 0.01% LT5400AIMS8E-1 + AD8130)
* Transfer: V(VOUT_P, VOUT_N) = (1/2) * [VA + VB + VC + VD]
* Each LT5400AIMS8E-1 houses 4 die-matched 1.00 kOhm (+/-0.01%, 0.2 ppm/C) resistors!
* ------------------------------------------------------------------------------
.SUBCKT LT5400_4TAP_SUMMER VA_P VA_N VB_P VB_N VC_P VC_N VD_P VD_N VOUT_P VOUT_N AGND
R_MAP VA_P IA_P {R_ON_MUX}
R_MAN VA_N IA_N {R_ON_MUX}
R_MBP VB_P IB_P {R_ON_MUX}
R_MBN VB_N IB_N {R_ON_MUX}
R_MCP VC_P IC_P {R_ON_MUX}
R_MCN VC_N IC_N {R_ON_MUX}
R_MDP VD_P ID_P {R_ON_MUX}
R_MDN VD_N ID_N {R_ON_MUX}
* LT5400AIMS8E-1 #1 (Positive Rail Quad 1.00 kOhm 0.01%)
R_LT1_1 IA_P SUM4_P {R_SUM_FOIL}
R_LT1_2 IB_P SUM4_P {R_SUM_FOIL}
R_LT1_3 IC_P SUM4_P {R_SUM_FOIL}
R_LT1_4 ID_P SUM4_P {R_SUM_FOIL}
* LT5400AIMS8E-1 #2 (Negative Rail Quad 1.00 kOhm 0.01%)
R_LT2_1 IA_N SUM4_N {R_SUM_FOIL}
R_LT2_2 IB_N SUM4_N {R_SUM_FOIL}
R_LT2_3 IC_N SUM4_N {R_SUM_FOIL}
R_LT2_4 ID_N SUM4_N {R_SUM_FOIL}
R_SH4_P SUM4_P AGND {R_SHUNT_4T}
R_SH4_N SUM4_N AGND {R_SHUNT_4T}
E_AMP4_P AMP4_P AGND SUM4_P SUM4_N 1.25000000
E_AMP4_N AMP4_N AGND SUM4_N SUM4_P 1.25000000
R_O4P AMP4_P VOUT_P {R_FILT}
R_O4N AMP4_N VOUT_N {R_FILT}
C_AA4 VOUT_P VOUT_N {C_FILT}
R_T4  VOUT_P VOUT_N 100.0K
.ENDS LT5400_4TAP_SUMMER

* ------------------------------------------------------------------------------
* SUBCKT: ADL5565_INTERSTAGE_BUF (6 GHz +46 dBm OIP3 Unity-Gain Diff Isolation)
* ------------------------------------------------------------------------------
.SUBCKT ADL5565_INTERSTAGE_BUF IN_P IN_N OUT_P OUT_N AGND
R_IN_DIFF IN_P IN_N 200.0
E_BUF_P   B_P  AGND IN_P IN_N 0.5000
E_BUF_N   B_N  AGND IN_N IN_P 0.5000
R_ZO_P    B_P  OUT_P 5.0
R_ZO_N    B_N  OUT_N 5.0
C_ISO_P   OUT_P AGND 1.2p
C_ISO_N   OUT_N AGND 1.2p
.ENDS ADL5565_INTERSTAGE_BUF

* ------------------------------------------------------------------------------
* SUBCKT: STAGE1_2TAP_SLICE & STAGE2_4TAP_SLICE
* ------------------------------------------------------------------------------
.SUBCKT STAGE1_2TAP_SLICE CHA_P CHA_N CHB_P CHB_N POL_A POL_B VOUT_P VOUT_N AGND
X_DA CHA_P CHA_N VPA_P VPA_N POL_A AGND ADG1611_DPDT_BRIDGE
X_DB CHB_P CHB_N VPB_P VPB_N POL_B AGND ADG1611_DPDT_BRIDGE
X_S2 VPA_P VPA_N VPB_P VPB_N VOUT_P VOUT_N AGND FOIL_2TAP_SUMMER
.ENDS STAGE1_2TAP_SLICE

.SUBCKT STAGE2_4TAP_SLICE CA_P CA_N CB_P CB_N CC_P CC_N CD_P CD_N PA PB PC PD VOUT_P VOUT_N AGND
X_DA CA_P CA_N YA_P YA_N PA AGND ADG1611_DPDT_BRIDGE
X_DB CB_P CB_N YB_P YB_N PB AGND ADG1611_DPDT_BRIDGE
X_DC CC_P CC_N YC_P YC_N PC AGND ADG1611_DPDT_BRIDGE
X_DD CD_P CD_N YD_P YD_N PD AGND ADG1611_DPDT_BRIDGE
X_S4 YA_P YA_N YB_P YB_N YC_P YC_N YD_P YD_N VOUT_P VOUT_N AGND LT5400_4TAP_SUMMER
.ENDS STAGE2_4TAP_SLICE

* ==============================================================================
* TOP-LEVEL STIMULUS:
*   - Jammer 1 (10 MHz, 2.5 Vpk): U1 on e_1 + e_10
*   - Jammer 2 (13 MHz, 2.5 Vpk): U2 on e_1 + e_13
*   - Desired Signal (2.0 MHz, 0.25 Vpk): S on e_2
* ==============================================================================
V_J1_P  VJ1_P  0 SIN(0  2.50 10MEG)
V_J1_N  VJ1_N  0 SIN(0 -2.50 10MEG)
V_J2_P  VJ2_P  0 SIN(0  2.50 13MEG)
V_J2_N  VJ2_N  0 SIN(0 -2.50 13MEG)
V_SIG_P VSIG_P 0 SIN(0  0.25  2MEG)
V_SIG_N VSIG_N 0 SIN(0 -0.25  2MEG)

E_VIN1_P  VIN1_P  0 VALUE = { V(VJ1_P) + V(VJ2_P) }
E_VIN1_N  VIN1_N  0 VALUE = { V(VJ1_N) + V(VJ2_N) }
E_VIN10_P VIN10_P 0 VJ1_P 0 1.0
E_VIN10_N VIN10_N 0 VJ1_N 0 1.0
E_VIN13_P VIN13_P 0 VJ2_P 0 1.0
E_VIN13_N VIN13_N 0 VJ2_N 0 1.0
E_VIN2_P  VIN2_P  0 VSIG_P 0 1.0
E_VIN2_N  VIN2_N  0 VSIG_N 0 1.0

R_G9P  VIN9_P  0 50.0
R_G9N  VIN9_N  0 50.0
R_G6P  VIN6_P  0 50.0
R_G6N  VIN6_N  0 50.0
R_G12P VIN12_P 0 50.0
R_G12N VIN12_N 0 50.0
R_G15P VIN15_P 0 50.0
R_G15N VIN15_N 0 50.0

V_LOGIC_POS V_POS1 0 DC 0.0
V_LOGIC_NEG V_NEG1 0 DC 3.3

* Stage 1 Active Slices for W1 = (e_4 - e_15)/sqrt(2) + ADL5565 Buffers:
*   U1*W1 = 0 everywhere; U2*W1 lands on {2, 5, 9, 14}; S*W1 lands on {6, 13}
X_STG1_2  VIN6_P  VIN6_N  VIN13_P VIN13_N V_NEG1 V_POS1 S1_2_P  S1_2_N  0 STAGE1_2TAP_SLICE
X_STG1_5  VIN1_P  VIN1_N  VIN10_P VIN10_N V_POS1 V_NEG1 S1_5_P  S1_5_N  0 STAGE1_2TAP_SLICE
X_STG1_6  VIN2_P  VIN2_N  VIN9_P  VIN9_N  V_POS1 V_POS1 S1_6_P  S1_6_N  0 STAGE1_2TAP_SLICE
X_STG1_9  VIN13_P VIN13_N VIN6_P  VIN6_N  V_POS1 V_NEG1 S1_9_P  S1_9_N  0 STAGE1_2TAP_SLICE
X_STG1_13 VIN9_P  VIN9_N  VIN2_P  VIN2_N  V_NEG1 V_NEG1 S1_13_P S1_13_N 0 STAGE1_2TAP_SLICE
X_STG1_14 VIN10_P VIN10_N VIN1_P  VIN1_N  V_NEG1 V_POS1 S1_14_P S1_14_N 0 STAGE1_2TAP_SLICE

X_BUF_2  S1_2_P  S1_2_N  B1_2_P  B1_2_N  0 ADL5565_INTERSTAGE_BUF
X_BUF_5  S1_5_P  S1_5_N  B1_5_P  B1_5_N  0 ADL5565_INTERSTAGE_BUF
X_BUF_6  S1_6_P  S1_6_N  B1_6_P  B1_6_N  0 ADL5565_INTERSTAGE_BUF
X_BUF_9  S1_9_P  S1_9_N  B1_9_P  B1_9_N  0 ADL5565_INTERSTAGE_BUF
X_BUF_13 S1_13_P S1_13_N B1_13_P B1_13_N 0 ADL5565_INTERSTAGE_BUF
X_BUF_14 S1_14_P S1_14_N B1_14_P B1_14_N 0 ADL5565_INTERSTAGE_BUF

* Stage 2 Representative Slices for W2 = (e_1 - e_6 + e_10 - e_13)/2:
*   k=3:  Taps 3^1=2, 3^6=5, 3^10=9, 3^13=14 (cancels Jammer 2 U2' to exact ZERO!)
*   k=0:  Taps 0^1=1, 0^6=6, 0^10=10, 0^13=13 (cancels scalar component to ZERO!)
*   k=12: Taps 12^1=13, 12^6=10, 12^10=6, 12^13=1 (passes Desired Signal S = e_2 via [e_2, W1, W2]!)
R_B1_1P  B1_1_P  0 50.0
R_B1_1N  B1_1_N  0 50.0
R_B1_10P B1_10_P 0 50.0
R_B1_10N B1_10_N 0 50.0
X_STG2_3  B1_2_P  B1_2_N  B1_5_P  B1_5_N  B1_9_P  B1_9_N  B1_14_P B1_14_N V_NEG1 V_POS1 V_NEG1 V_POS1 VADC3_P  VADC3_N  0 STAGE2_4TAP_SLICE
X_STG2_0  B1_1_P  B1_1_N  B1_6_P  B1_6_N  B1_10_P B1_10_N B1_13_P B1_13_N V_NEG1 V_POS1 V_NEG1 V_POS1 VADC0_P  VADC0_N  0 STAGE2_4TAP_SLICE
X_STG2_12 B1_13_P B1_13_N B1_10_P B1_10_N B1_6_P  B1_6_N  B1_1_P  B1_1_N  V_NEG1 V_NEG1 V_NEG1 V_NEG1 VADC12_P VADC12_N 0 STAGE2_4TAP_SLICE

.TRAN 1.0n 1000.0n
.END
